* Lab 3 L3 — DFF testbench stimulus template (connect to your XSchem netlist)
* Replace .include with netlisted dff subckt from xschem
.lib $PDK_ROOT/sky130A/libs.tech/ngspice/sky130.lib.spice tt
* .include dff.spice
Vdd vdd 0 1.8
Vss vss 0 0
* Example PULSE params — match legacy handout Fig timing
Vclk clk 0 PULSE(0 1.8 0 100p 100p 5n 10n)
Vdata data 0 PULSE(0 1.8 2n 100p 100p 4n 20n)
Vcl cl 0 PULSE(0 1.8 0 100p 100p 8n 16n)
Vsetq setq 0 PULSE(0 1.8 12n 100p 100p 2n 40n)
Vresetq resetq 0 PULSE(0 1.8 18n 100p 100p 2n 40n)
.tran 10p 250n
.control
run
* wrdata dff_cl.txt v(cl) v(cl_b)
* wrdata dff_q.txt v(q) v(q_b)
.endc
.end
