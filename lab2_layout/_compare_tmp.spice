* ECE334 Lab 2 L6 -- NAND2 timing, ideal devices vs extracted parasitics
*
* Run twice, changing only the .include line:
*   .include nand2.lvs.spice   -- devices only, no parasitics
*   .include nand2.pex.spice   -- same devices plus every extracted coupling cap
*
* Both netlists come from the same layout, so any difference in the measured
* delays is the parasitics and nothing else.
*
*   ngspice -b nand2_compare.spice

.lib $PDK_ROOT/sky130A/libs.tech/ngspice/sky130.lib.spice tt
.include nand2.lvs.spice

.param CLOAD=0.1p

Vdd  vdd 0 1.8
Vss  vss 0 0
* Hold b high so the gate acts as an inverter on a.
Vb   b   0 1.8
Va   a   0 PULSE(0 1.8 1n 0.2n 0.2n 6n 12n)

Xdut a b out vdd vss nand2
CL   out vss {CLOAD}

.tran 1p 24n

.control
run
set filetype=ascii
write nand2_wave.raw v(a) v(out)
meas tran tpHL  TRIG v(a)   VAL=0.9  RISE=1 TARG v(out) VAL=0.9  FALL=1
meas tran tpLH  TRIG v(a)   VAL=0.9  FALL=1 TARG v(out) VAL=0.9  RISE=1
meas tran trise TRIG v(out) VAL=0.18 RISE=1 TARG v(out) VAL=1.62 RISE=1
meas tran tfall TRIG v(out) VAL=1.62 FALL=1 TARG v(out) VAL=0.18 FALL=1
.endc
.end
