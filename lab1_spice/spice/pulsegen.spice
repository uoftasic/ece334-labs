* ECE334 Lab 1 P4/L4 -- transistor-level pulse generator
*
*   in ---+--[inv]--[inv]--[inv]--> n3 --> NAND2.b
*         |                                NAND2.a
*         +--------------------------------^
*
* Both NAND inputs are high only while "in" is high and n3 has not yet fallen,
* so "out" carries a low-going pulse whose width is the delay of the three
* inverter stages. That delay is the RC charge of P1 with the transistor's Req
* from P2 in place of the resistor.
*
* This deck reproduces xschem/pulsegen_tb.sch exactly, including the source and
* drain diffusion geometry (ad/as/pd/ps/nrd/nrs) that the XSchem device symbols
* compute for you. Those junction capacitances are a real part of the delay:
* omitting them makes the pulse about 25 % narrower and the two routes disagree.
*
* Terminal route:  ngspice -b pulsegen.spice

.lib $PDK_ROOT/sky130A/libs.tech/ngspice/sky130.lib.spice tt

.param WN=1 WP=3 LL=0.5
.param CN3=0

* Diffusion geometry, as generated by the sky130 XSchem symbols for nf=1.
.param adn='0.29*WN'  pdn='2*(WN+0.29)'  nrn='0.29/WN'
.param adp='0.29*WP'  pdp='2*(WP+0.29)'  nrp='0.29/WP'
.param adx='0.29*2*WN' pdx='2*(2*WN+0.29)' nrx='0.29/(2*WN)'

Vdd vdd 0 1.8
Vss vss 0 0
Vin in  0 PULSE(0 1.8 1n 0.2n 0.2n 10n 20n)

.subckt inv in out vdd vss
XM2 out in vdd vdd sky130_fd_pr__pfet_01v8 L={LL} W={WP} nf=1
+ ad={adp} as={adp} pd={pdp} ps={pdp} nrd={nrp} nrs={nrp} sa=0 sb=0 sd=0 mult=1
XM1 out in vss vss sky130_fd_pr__nfet_01v8 L={LL} W={WN} nf=1
+ ad={adn} as={adn} pd={pdn} ps={pdn} nrd={nrn} nrs={nrn} sa=0 sb=0 sd=0 mult=1
.ends

.subckt nand2 a b out vdd vss
XMPA out a vdd vdd sky130_fd_pr__pfet_01v8 L={LL} W={WP} nf=1
+ ad={adp} as={adp} pd={pdp} ps={pdp} nrd={nrp} nrs={nrp} sa=0 sb=0 sd=0 mult=1
XMPB out b vdd vdd sky130_fd_pr__pfet_01v8 L={LL} W={WP} nf=1
+ ad={adp} as={adp} pd={pdp} ps={pdp} nrd={nrp} nrs={nrp} sa=0 sb=0 sd=0 mult=1
XMNA out a mid vss sky130_fd_pr__nfet_01v8 L={LL} W={2*WN} nf=1
+ ad={adx} as={adx} pd={pdx} ps={pdx} nrd={nrx} nrs={nrx} sa=0 sb=0 sd=0 mult=1
XMNB mid b vss vss sky130_fd_pr__nfet_01v8 L={LL} W={2*WN} nf=1
+ ad={adx} as={adx} pd={pdx} ps={pdx} nrd={nrx} nrs={nrx} sa=0 sb=0 sd=0 mult=1
.ends

xi1 in  n1 vdd vss inv
xi2 n1  n2 vdd vss inv
xi3 n2  n3 vdd vss inv
xn1 in  n3 out vdd vss nand2

* Load at the chain output -- the lever for the 1.5 ns design task in L4.
Cn3 n3 vss {CN3}

.tran 1p 25n

.control
run
set filetype=ascii
write pulsegen.raw v(in) v(n3) v(out)
meas tran pw TRIG v(out) VAL=0.9 FALL=1 TARG v(out) VAL=0.9 RISE=1
.endc
.end
