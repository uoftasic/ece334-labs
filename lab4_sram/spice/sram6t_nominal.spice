* Lab 4 — 6T SRAM nominal (template — replace with xschem netlist)
* Illustrative device widths @ L=0.5u; confirm in pilot
.lib $PDK_ROOT/sky130A/libs.tech/ngspice/sky130.lib.spice tt
* .include sram6t.spice
Vdd vdd 0 1.8
Vss vss 0 0
.ic v(A)=0
* Precharge, word, write drivers — add per handout Fig. 3 (1.8 V levels)
.tran 10p 100n
.control
run
* .meas tran tread trig v(word) val=0.9 rise=1 targ abs(v(bit)-v(bit_b)) val=0.2 rise=1
.endc
.end
