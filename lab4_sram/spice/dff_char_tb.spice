* Lab 4 L1/L2 — DFF characterization template
* Include your Lab 3 DFF subckt after xschem netlist:
* .include dff.spice
.lib $PDK_ROOT/sky130A/libs.tech/ngspice/sky130.lib.spice tt
Vdd vdd 0 1.8
Vss vss 0 0
* Sweep delay on clock PULSE — adjust 4th parameter (delay)
Vclk clk 0 PULSE(0 1.8 0 100p 100p 5n 10n)
Vd data 0 PULSE(0 1.8 1n 100p 100p 3n 20n)
.tran 10p 80n
.control
run
wrdata dff_char.txt v(clk) v(data) v(q)
.meas tran tpcq trig v(clk) val=0.9 rise=1 targ v(q) val=0.9 rise=1
print tpcq
.endc
.end
