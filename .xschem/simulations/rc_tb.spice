** sch_path: /foss/designs/lab1_spice/xschem/rc_tb.sch
**.subckt rc_tb
Vin in 0 PULSE(0 1.8 0 0.2n 0.2n 3n 6n)
R1 in out 1k
R2 out 0 2k
C1 out 0 0.7p
**** begin user architecture code

.control
save all
set filetype=ascii
tran 1p 15n
write rc_tb.raw v(in) v(out)
.endc

**** end user architecture code
**.ends
.end
